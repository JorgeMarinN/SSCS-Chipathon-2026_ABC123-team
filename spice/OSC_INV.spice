** sch_path: /foss/designs/SSCS-Chipathon-2026_ABC123-team/ABC123_SDC/design_data/xschem/OSC_INV/OSC_INV.sch
.subckt OSC_INV VDD VIN VOUT VSS Vcont
*.PININFO VIN:I VOUT:O VDD:B VSS:B Vcont:I
M4 Nnet mirror VSS VSS nfet_03v3 L=2.5u W=0.22u nf=8
M5 Pnet mirror2 VDD VDD pfet_03v3 L=2.5u W=0.29u nf=8
M6 mirror2 mirror VSS VSS nfet_03v3 L=2.5u W=0.22u nf=4
M7 mirror2 mirror2 VDD VDD pfet_03v3 L=2.5u W=0.29u nf=4
M8 mirror mirror VSS VSS nfet_03v3 L=2.5u W=0.22u nf=4
M9 mirror Vcont VDD VDD pfet_03v3 L=2.5u W=0.29u nf=4
M1 VOUT VIN Pnet VDD pfet_03v3 L=2.5u W=15.825u nf=10
M2 VOUT VIN Nnet VSS nfet_03v3 L=0.5u W=6.33u nf=10
.ends
