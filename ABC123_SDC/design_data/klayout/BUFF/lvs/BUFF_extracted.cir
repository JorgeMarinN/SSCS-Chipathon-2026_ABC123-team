* Extracted by KLayout with GF180MCU LVS runset on : 24/08/2026 16:27

.SUBCKT BUFF
M$1 VDD VIN \$2 VDD pfet_03v3 L=0.28U W=1.87U AS=2.057P AD=0.4862P PS=5.94U
+ PD=2.39U
M$2 VOUT \$2 VDD VDD pfet_03v3 L=0.28U W=1.87U AS=0.4862P AD=2.057P PS=2.39U
+ PD=5.94U
M$3 VSS VIN \$2 VSS nfet_03v3 L=0.28U W=1.87U AS=2.057P AD=0.4862P PS=5.94U
+ PD=2.39U
M$4 VOUT \$2 VSS VSS nfet_03v3 L=0.28U W=1.87U AS=0.4862P AD=2.057P PS=2.39U
+ PD=5.94U
.ENDS BUFF
