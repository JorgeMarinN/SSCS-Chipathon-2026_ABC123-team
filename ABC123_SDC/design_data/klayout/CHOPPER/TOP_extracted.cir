* Extracted by KLayout with GF180MCU LVS runset on : 23/08/2026 01:13

.SUBCKT TOP
X$1 SUB SUB SUB SUB SUB SUB SUB SUB SUB SUB SUB SUB SUB SUB SUB SUB SUB SUB SUB
+ SUB SUB SUB SUB SUB SUB SUB SUB SUB SUB SUB SUB SUB SUB SUB SUB SUB SUB SUB
+ SUB SUB SUB SUB SUB SUB SUB SUB SUB SUB SUB SUB SUB SUB SUB SUB SUB SUB SUB
+ SUB SUB SUB SUB SUB SUB SUB SUB \$I546 \$I519 \$I534 \$I522 \$I537 \$I525
+ \$I540 \$I528 \$I543 \$I531 \$I516 SUB SUB SUB SUB SUB SUB SUB SUB SUB SUB
+ SUB SUB SUB SUB SUB SUB SUB SUB SUB \$I579 SUB SUB SUB \$I576 \$I570 \$I549
+ \$I573 \$I564 \$I552 \$I567 \$I555 \$I558 \$I561 \$4 \$42 \$4 \$42 \$4 \$42
+ \$4 \$42 \$4 \$42 \$4 \$42 \$4 \$42 \$4 \$42 \$4 \$42 \$4 \$42 SUB SUB SUB
+ SUB SUB SUB SUB SUB SUB SUB SUB SUB SUB SUB SUB SUB SUB SUB SUB SUB SUB SUB
+ SUB SUB SUB SUB SUB SUB SUB SUB SUB SUB SUB SUB SUB SUB SUB SUB SUB SUB SUB
+ SUB SUB SUB SUB SUB SUB SUB SUB SUB SUB SUB SUB SUB SUB SUB SUB SUB SUB SUB
+ SUB SUB SUB SUB nfet
X$2 SUB SUB SUB SUB SUB SUB SUB SUB SUB SUB SUB SUB SUB SUB SUB SUB SUB SUB SUB
+ SUB SUB SUB SUB SUB SUB SUB SUB SUB SUB SUB SUB SUB SUB SUB SUB SUB SUB SUB
+ SUB SUB SUB SUB SUB SUB SUB SUB SUB SUB SUB SUB SUB SUB SUB SUB SUB SUB SUB
+ SUB SUB SUB SUB SUB SUB SUB SUB \$I544 \$I517 \$I532 \$I520 \$I535 \$I523
+ \$I538 \$I526 \$I541 \$I529 \$I514 SUB SUB SUB SUB SUB SUB SUB SUB SUB SUB
+ SUB SUB SUB SUB SUB SUB SUB SUB SUB \$I577 SUB SUB SUB \$I574 \$I568 \$I547
+ \$I571 \$I562 \$I550 \$I565 \$I553 \$I556 \$I559 \$9 \$40 \$9 \$40 \$9 \$40
+ \$9 \$40 \$9 \$40 \$9 \$40 \$9 \$40 \$9 \$40 \$9 \$40 \$9 \$40 SUB SUB SUB
+ SUB SUB SUB SUB SUB SUB SUB SUB SUB SUB SUB SUB SUB SUB SUB SUB SUB SUB SUB
+ SUB SUB SUB SUB SUB SUB SUB SUB SUB SUB SUB SUB SUB SUB SUB SUB SUB SUB SUB
+ SUB SUB SUB SUB SUB SUB SUB SUB SUB SUB SUB SUB SUB SUB SUB SUB SUB SUB SUB
+ SUB SUB SUB SUB nfet
X$3 SUB SUB SUB SUB SUB SUB SUB SUB SUB SUB SUB SUB SUB SUB SUB SUB SUB SUB SUB
+ SUB SUB SUB SUB SUB SUB SUB SUB SUB SUB SUB SUB SUB SUB SUB SUB SUB SUB SUB
+ SUB SUB SUB SUB SUB SUB SUB SUB SUB SUB SUB SUB SUB SUB SUB SUB SUB SUB SUB
+ SUB SUB SUB SUB SUB SUB SUB SUB \$47 \$45 \$46 \$45 \$46 \$45 \$46 \$45 \$46
+ \$45 \$44 SUB SUB SUB SUB SUB SUB SUB SUB SUB SUB SUB SUB SUB SUB SUB SUB SUB
+ SUB SUB \$64 SUB SUB SUB \$63 \$61 \$52 \$62 \$59 \$55 \$60 \$56 \$57 \$58
+ \$38 \$43 \$38 \$43 \$38 \$43 \$38 \$43 \$38 \$43 \$38 \$43 \$38 \$43 \$38
+ \$43 \$38 \$43 \$38 \$43 SUB SUB SUB SUB SUB SUB SUB SUB SUB SUB SUB SUB SUB
+ SUB SUB SUB SUB SUB SUB SUB SUB SUB SUB SUB SUB SUB SUB SUB SUB SUB SUB SUB
+ SUB SUB SUB SUB SUB SUB SUB SUB SUB SUB SUB SUB SUB SUB SUB SUB SUB SUB SUB
+ SUB SUB SUB SUB SUB SUB SUB SUB SUB SUB SUB SUB SUB nfet
X$4 SUB SUB SUB SUB SUB SUB SUB SUB SUB SUB SUB SUB SUB SUB SUB SUB SUB SUB SUB
+ SUB SUB SUB SUB SUB SUB SUB SUB SUB SUB SUB SUB SUB SUB SUB SUB SUB SUB SUB
+ SUB SUB SUB SUB SUB SUB SUB SUB SUB SUB SUB SUB SUB SUB SUB SUB SUB SUB SUB
+ SUB SUB SUB SUB SUB SUB SUB SUB \$48 \$49 \$50 \$49 \$50 \$49 \$50 \$49 \$50
+ \$49 \$51 SUB SUB SUB SUB SUB SUB SUB SUB SUB SUB SUB SUB SUB SUB SUB SUB SUB
+ SUB SUB \$65 SUB SUB SUB \$66 \$68 \$75 \$69 \$67 \$74 \$71 \$70 \$72 \$73
+ \$39 \$41 \$39 \$41 \$39 \$41 \$39 \$41 \$39 \$41 \$39 \$41 \$39 \$41 \$39
+ \$41 \$39 \$41 \$39 \$41 SUB SUB SUB SUB SUB SUB SUB SUB SUB SUB SUB SUB SUB
+ SUB SUB SUB SUB SUB SUB SUB SUB SUB SUB SUB SUB SUB SUB SUB SUB SUB SUB SUB
+ SUB SUB SUB SUB SUB SUB SUB SUB SUB SUB SUB SUB SUB SUB SUB SUB SUB SUB SUB
+ SUB SUB SUB SUB SUB SUB SUB SUB SUB SUB SUB SUB SUB nfet
.ENDS TOP

.SUBCKT nfet \$1 \$2 \$3 \$4 \$5 \$6 \$7 \$8 \$9 \$10 \$11 \$12 \$13 \$14 \$15
+ \$16 \$17 \$18 \$19 \$20 \$21 \$22 \$23 \$24 \$25 \$26 \$27 \$28 \$29 \$30
+ \$31 \$32 \$33 \$34 \$35 \$36 \$37 \$38 \$39 \$40 \$41 \$42 \$43 \$44 \$45
+ \$46 \$47 \$48 \$49 \$50 \$51 \$52 \$53 \$54 \$55 \$56 \$57 \$58 \$59 \$60
+ \$61 \$62 \$63 \$64 \$65 \$66 \$67 \$68 \$69 \$70 \$71 \$72 \$73 \$74 \$75
+ \$76 \$77 \$78 \$79 \$80 \$81 \$82 \$83 \$84 \$85 \$86 \$87 \$88 \$89 \$90
+ \$91 \$92 \$93 \$94 \$95 \$96 \$97 \$98 \$99 \$100 \$101 \$102 \$103 \$104
+ \$105 \$106 \$107 \$108 \$109 \$110 \$111 \$112 \$113 \$114 \$115 \$116 \$117
+ \$118 \$119 \$120 \$121 \$122 \$123 \$124 \$125 \$126 \$127 \$128 \$129 \$130
+ \$131 \$132 \$133 \$134 \$135 \$136 \$137 \$138 \$139 \$140 \$141 \$142 \$143
+ \$144 \$145 \$146 \$147 \$148 \$149 \$150 \$151 \$152 \$153 \$154 \$155 \$156
+ \$157 \$158 \$159 \$160 \$161 \$162 \$163 \$164 \$165 \$166 \$167 \$168 \$169
+ \$170 \$171 \$172 \$173 \$174 \$175 \$176 \$177 \$179 \$180 \$181 \$182 \$183
+ \$184 \$185 \$186 \$187 \$188 \$189 \$190 \$191 \$192 \$193 \$194
M$1 \$67 \$111 \$66 \$1 nfet_03v3 L=0.28U W=6U AS=3.66P AD=1.56P PS=13.22U
+ PD=6.52U
M$2 \$68 \$113 \$67 \$1 nfet_03v3 L=0.28U W=6U AS=1.56P AD=1.56P PS=6.52U
+ PD=6.52U
M$3 \$69 \$115 \$68 \$1 nfet_03v3 L=0.28U W=6U AS=1.56P AD=1.56P PS=6.52U
+ PD=6.52U
M$4 \$70 \$117 \$69 \$1 nfet_03v3 L=0.28U W=6U AS=1.56P AD=1.56P PS=6.52U
+ PD=6.52U
M$5 \$71 \$119 \$70 \$1 nfet_03v3 L=0.28U W=6U AS=1.56P AD=1.56P PS=6.52U
+ PD=6.52U
M$6 \$72 \$121 \$71 \$1 nfet_03v3 L=0.28U W=6U AS=1.56P AD=1.56P PS=6.52U
+ PD=6.52U
M$7 \$73 \$123 \$72 \$1 nfet_03v3 L=0.28U W=6U AS=1.56P AD=1.56P PS=6.52U
+ PD=6.52U
M$8 \$74 \$125 \$73 \$1 nfet_03v3 L=0.28U W=6U AS=1.56P AD=1.56P PS=6.52U
+ PD=6.52U
M$9 \$75 \$127 \$74 \$1 nfet_03v3 L=0.28U W=6U AS=1.56P AD=1.56P PS=6.52U
+ PD=6.52U
M$10 \$76 \$129 \$75 \$1 nfet_03v3 L=0.28U W=6U AS=1.56P AD=3.66P PS=6.52U
+ PD=13.22U
.ENDS nfet
