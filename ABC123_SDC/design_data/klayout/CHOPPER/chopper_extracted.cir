* Extracted by KLayout with GF180MCU LVS runset on : 23/08/2026 01:18

.SUBCKT chopper SUB
M$1 \$I519 \$42 \$I546 SUB nfet_03v3 L=0.28U W=6U AS=3.66P AD=1.56P PS=13.22U
+ PD=6.52U
M$2 \$I534 \$42 \$I519 SUB nfet_03v3 L=0.28U W=6U AS=1.56P AD=1.56P PS=6.52U
+ PD=6.52U
M$3 \$I522 \$42 \$I534 SUB nfet_03v3 L=0.28U W=6U AS=1.56P AD=1.56P PS=6.52U
+ PD=6.52U
M$4 \$I537 \$42 \$I522 SUB nfet_03v3 L=0.28U W=6U AS=1.56P AD=1.56P PS=6.52U
+ PD=6.52U
M$5 \$I525 \$42 \$I537 SUB nfet_03v3 L=0.28U W=6U AS=1.56P AD=1.56P PS=6.52U
+ PD=6.52U
M$6 \$I540 \$42 \$I525 SUB nfet_03v3 L=0.28U W=6U AS=1.56P AD=1.56P PS=6.52U
+ PD=6.52U
M$7 \$I528 \$42 \$I540 SUB nfet_03v3 L=0.28U W=6U AS=1.56P AD=1.56P PS=6.52U
+ PD=6.52U
M$8 \$I543 \$42 \$I528 SUB nfet_03v3 L=0.28U W=6U AS=1.56P AD=1.56P PS=6.52U
+ PD=6.52U
M$9 \$I531 \$42 \$I543 SUB nfet_03v3 L=0.28U W=6U AS=1.56P AD=1.56P PS=6.52U
+ PD=6.52U
M$10 \$I516 \$42 \$I531 SUB nfet_03v3 L=0.28U W=6U AS=1.56P AD=3.66P PS=6.52U
+ PD=13.22U
M$11 \$I517 \$40 \$I544 SUB nfet_03v3 L=0.28U W=6U AS=3.66P AD=1.56P PS=13.22U
+ PD=6.52U
M$12 \$I532 \$40 \$I517 SUB nfet_03v3 L=0.28U W=6U AS=1.56P AD=1.56P PS=6.52U
+ PD=6.52U
M$13 \$I520 \$40 \$I532 SUB nfet_03v3 L=0.28U W=6U AS=1.56P AD=1.56P PS=6.52U
+ PD=6.52U
M$14 \$I535 \$40 \$I520 SUB nfet_03v3 L=0.28U W=6U AS=1.56P AD=1.56P PS=6.52U
+ PD=6.52U
M$15 \$I523 \$40 \$I535 SUB nfet_03v3 L=0.28U W=6U AS=1.56P AD=1.56P PS=6.52U
+ PD=6.52U
M$16 \$I538 \$40 \$I523 SUB nfet_03v3 L=0.28U W=6U AS=1.56P AD=1.56P PS=6.52U
+ PD=6.52U
M$17 \$I526 \$40 \$I538 SUB nfet_03v3 L=0.28U W=6U AS=1.56P AD=1.56P PS=6.52U
+ PD=6.52U
M$18 \$I541 \$40 \$I526 SUB nfet_03v3 L=0.28U W=6U AS=1.56P AD=1.56P PS=6.52U
+ PD=6.52U
M$19 \$I529 \$40 \$I541 SUB nfet_03v3 L=0.28U W=6U AS=1.56P AD=1.56P PS=6.52U
+ PD=6.52U
M$20 \$I514 \$40 \$I529 SUB nfet_03v3 L=0.28U W=6U AS=1.56P AD=3.66P PS=6.52U
+ PD=13.22U
M$21 \$45 \$43 \$47 SUB nfet_03v3 L=0.28U W=6U AS=3.66P AD=1.56P PS=13.22U
+ PD=6.52U
M$22 \$46 \$43 \$45 SUB nfet_03v3 L=0.28U W=48U AS=12.48P AD=12.48P PS=52.16U
+ PD=52.16U
M$30 \$44 \$43 \$45 SUB nfet_03v3 L=0.28U W=6U AS=1.56P AD=3.66P PS=6.52U
+ PD=13.22U
M$31 \$48 \$41 \$48 SUB nfet_03v3 L=0.28U W=6U AS=3.66P AD=1.56P PS=13.22U
+ PD=6.52U
M$32 \$49 \$41 \$48 SUB nfet_03v3 L=0.28U W=54U AS=14.04P AD=16.14P PS=58.68U
+ PD=65.38U
.ENDS chopper
