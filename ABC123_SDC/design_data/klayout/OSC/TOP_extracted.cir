* Extracted by KLayout with GF180MCU LVS runset on : 14/08/2026 14:43

.SUBCKT TOP
X$1 \$14 \$12 \$12 \$12 \$12 \$12 \$12 \$12 \$12 \$12 \$12 \$3 \$15 pfet$2
X$2 \$3 \$8 SUB \$9 \$13 \$13 \$13 \$13 \$13 \$13 \$13 \$13 \$13 \$13 \$11 \$11
+ \$11 \$11 \$11 \$11 \$11 \$11 \$11 \$11 SUB nfet$3
X$3 \$7 SUB \$4 \$4 \$4 \$4 SUB nfet
X$4 \$8 SUB \$4 \$4 \$4 \$4 \$4 \$4 \$4 \$4 SUB nfet$6
X$5 \$4 SUB \$4 \$4 \$4 \$4 SUB nfet
X$6 \$4 \$18 \$20 \$20 \$20 \$20 \$18 \$22 pfet$1
X$7 \$7 \$18 \$7 \$7 \$7 \$7 \$18 \$22 pfet$1
X$8 \$15 \$18 \$7 \$7 \$7 \$7 \$7 \$7 \$7 \$7 \$18 \$22 pfet
.ENDS TOP

.SUBCKT nfet$3 \$2 \$3 \$4 \$6 \$16 \$17 \$18 \$19 \$20 \$21 \$22 \$23 \$24
+ \$25 \$26 \$27 \$28 \$29 \$30 \$31 \$32 \$33 \$34 \$35 SUB
M$1 \$7 \$16 \$2 \$4 nfet_03v3 L=2.5U W=6.33U AS=3.8613P AD=1.6458P PS=13.88U
+ PD=6.85U
M$2 \$8 \$17 \$7 \$4 nfet_03v3 L=2.5U W=6.33U AS=1.6458P AD=1.6458P PS=6.85U
+ PD=6.85U
M$3 \$5 \$18 \$8 \$4 nfet_03v3 L=2.5U W=6.33U AS=1.6458P AD=1.6458P PS=6.85U
+ PD=6.85U
M$4 \$9 \$19 \$5 \$4 nfet_03v3 L=2.5U W=6.33U AS=1.6458P AD=1.6458P PS=6.85U
+ PD=6.85U
M$5 \$10 \$20 \$9 \$4 nfet_03v3 L=2.5U W=6.33U AS=1.6458P AD=1.6458P PS=6.85U
+ PD=6.85U
M$6 \$12 \$21 \$10 \$4 nfet_03v3 L=2.5U W=6.33U AS=1.6458P AD=1.6458P PS=6.85U
+ PD=6.85U
M$7 \$11 \$22 \$12 \$4 nfet_03v3 L=2.5U W=6.33U AS=1.6458P AD=1.6458P PS=6.85U
+ PD=6.85U
M$8 \$13 \$23 \$11 \$4 nfet_03v3 L=2.5U W=6.33U AS=1.6458P AD=1.6458P PS=6.85U
+ PD=6.85U
M$9 \$14 \$24 \$13 \$4 nfet_03v3 L=2.5U W=6.33U AS=1.6458P AD=1.6458P PS=6.85U
+ PD=6.85U
M$10 \$3 \$25 \$14 \$4 nfet_03v3 L=2.5U W=6.33U AS=1.6458P AD=3.8613P PS=6.85U
+ PD=13.88U
.ENDS nfet$3

.SUBCKT pfet \$1 \$2 \$3 \$4 \$5 \$6 \$7 \$8 \$9 \$10 \$11 \$12
M$1 \$19 \$3 \$1 \$11 pfet_03v3 L=2.5U W=0.42U AS=0.2822P AD=0.1092P PS=2.18U
+ PD=0.94U
M$2 \$18 \$7 \$19 \$11 pfet_03v3 L=2.5U W=0.42U AS=0.1092P AD=0.1092P PS=0.94U
+ PD=0.94U
M$3 \$17 \$4 \$18 \$11 pfet_03v3 L=2.5U W=0.42U AS=0.1092P AD=0.1092P PS=0.94U
+ PD=0.94U
M$4 \$16 \$8 \$17 \$11 pfet_03v3 L=2.5U W=0.42U AS=0.1092P AD=0.1092P PS=0.94U
+ PD=0.94U
M$5 \$14 \$5 \$16 \$11 pfet_03v3 L=2.5U W=0.42U AS=0.1092P AD=0.1092P PS=0.94U
+ PD=0.94U
M$6 \$13 \$9 \$14 \$11 pfet_03v3 L=2.5U W=0.42U AS=0.1092P AD=0.1092P PS=0.94U
+ PD=0.94U
M$7 \$15 \$6 \$13 \$11 pfet_03v3 L=2.5U W=0.42U AS=0.1092P AD=0.1092P PS=0.94U
+ PD=0.94U
M$8 \$15 \$10 \$2 \$11 pfet_03v3 L=2.5U W=0.42U AS=0.2822P AD=0.1092P PS=2.18U
+ PD=0.94U
.ENDS pfet

.SUBCKT pfet$1 \$1 \$2 \$3 \$4 \$5 \$6 \$7 \$8
M$1 \$11 \$3 \$1 \$7 pfet_03v3 L=2.5U W=0.42U AS=0.2822P AD=0.1092P PS=2.18U
+ PD=0.94U
M$2 \$10 \$5 \$11 \$7 pfet_03v3 L=2.5U W=0.42U AS=0.1092P AD=0.1092P PS=0.94U
+ PD=0.94U
M$3 \$9 \$4 \$10 \$7 pfet_03v3 L=2.5U W=0.42U AS=0.1092P AD=0.1092P PS=0.94U
+ PD=0.94U
M$4 \$9 \$6 \$2 \$7 pfet_03v3 L=2.5U W=0.42U AS=0.2822P AD=0.1092P PS=2.18U
+ PD=0.94U
.ENDS pfet$1

.SUBCKT nfet$6 \$1 \$2 \$3 \$4 \$5 \$6 \$7 \$8 \$9 \$10 \$19
M$1 \$18 \$3 \$1 \$19 nfet_03v3 L=2.5U W=0.42U AS=0.2646P AD=0.1092P PS=2.1U
+ PD=0.94U
M$2 \$17 \$7 \$18 \$19 nfet_03v3 L=2.5U W=0.42U AS=0.1092P AD=0.1092P PS=0.94U
+ PD=0.94U
M$3 \$16 \$4 \$17 \$19 nfet_03v3 L=2.5U W=0.42U AS=0.1092P AD=0.1092P PS=0.94U
+ PD=0.94U
M$4 \$15 \$8 \$16 \$19 nfet_03v3 L=2.5U W=0.42U AS=0.1092P AD=0.1092P PS=0.94U
+ PD=0.94U
M$5 \$13 \$5 \$15 \$19 nfet_03v3 L=2.5U W=0.42U AS=0.1092P AD=0.1092P PS=0.94U
+ PD=0.94U
M$6 \$12 \$9 \$13 \$19 nfet_03v3 L=2.5U W=0.42U AS=0.1092P AD=0.1092P PS=0.94U
+ PD=0.94U
M$7 \$14 \$6 \$12 \$19 nfet_03v3 L=2.5U W=0.42U AS=0.1092P AD=0.1092P PS=0.94U
+ PD=0.94U
M$8 \$14 \$10 \$2 \$19 nfet_03v3 L=2.5U W=0.42U AS=0.2646P AD=0.1092P PS=2.1U
+ PD=0.94U
.ENDS nfet$6

.SUBCKT nfet \$1 \$2 \$3 \$4 \$5 \$6 \$15
M$1 \$10 \$3 \$1 \$15 nfet_03v3 L=2.5U W=0.42U AS=0.2646P AD=0.1092P PS=2.1U
+ PD=0.94U
M$2 \$9 \$5 \$10 \$15 nfet_03v3 L=2.5U W=0.42U AS=0.1092P AD=0.1092P PS=0.94U
+ PD=0.94U
M$3 \$8 \$4 \$9 \$15 nfet_03v3 L=2.5U W=0.42U AS=0.1092P AD=0.1092P PS=0.94U
+ PD=0.94U
M$4 \$8 \$6 \$2 \$15 nfet_03v3 L=2.5U W=0.42U AS=0.2646P AD=0.1092P PS=2.1U
+ PD=0.94U
.ENDS nfet

.SUBCKT pfet$2 \$1 \$2 \$3 \$4 \$5 \$6 \$7 \$8 \$9 \$10 \$11 \$12 \$13
M$1 \$15 \$2 \$12 \$1 pfet_03v3 L=2.5U W=15.825U AS=10.28625P AD=4.1145P
+ PS=32.95U PD=16.345U
M$2 \$14 \$3 \$15 \$1 pfet_03v3 L=2.5U W=15.825U AS=4.1145P AD=4.1145P
+ PS=16.345U PD=16.345U
M$3 \$17 \$4 \$14 \$1 pfet_03v3 L=2.5U W=15.825U AS=4.1145P AD=4.1145P
+ PS=16.345U PD=16.345U
M$4 \$16 \$5 \$17 \$1 pfet_03v3 L=2.5U W=15.825U AS=4.1145P AD=4.1145P
+ PS=16.345U PD=16.345U
M$5 \$19 \$6 \$16 \$1 pfet_03v3 L=2.5U W=15.825U AS=4.1145P AD=4.1145P
+ PS=16.345U PD=16.345U
M$6 \$18 \$7 \$19 \$1 pfet_03v3 L=2.5U W=15.825U AS=4.1145P AD=4.1145P
+ PS=16.345U PD=16.345U
M$7 \$21 \$8 \$18 \$1 pfet_03v3 L=2.5U W=15.825U AS=4.1145P AD=4.1145P
+ PS=16.345U PD=16.345U
M$8 \$20 \$9 \$21 \$1 pfet_03v3 L=2.5U W=15.825U AS=4.1145P AD=4.1145P
+ PS=16.345U PD=16.345U
M$9 \$22 \$10 \$20 \$1 pfet_03v3 L=2.5U W=15.825U AS=4.1145P AD=4.1145P
+ PS=16.345U PD=16.345U
M$10 \$13 \$11 \$22 \$1 pfet_03v3 L=2.5U W=15.825U AS=4.1145P AD=10.28625P
+ PS=16.345U PD=32.95U
.ENDS pfet$2
