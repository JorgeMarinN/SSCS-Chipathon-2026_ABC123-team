* Extracted by KLayout with GF180MCU LVS runset on : 14/08/2026 14:44

.SUBCKT OSC_INV SUB
M$1 \$I16 \$12 \$3 SUB nfet_03v3 L=2.5U W=6.33U AS=3.8613P AD=1.6458P PS=13.88U
+ PD=6.85U
M$2 \$I17 \$12 \$I16 SUB nfet_03v3 L=2.5U W=6.33U AS=1.6458P AD=1.6458P
+ PS=6.85U PD=6.85U
M$3 \$I15 \$12 \$I17 SUB nfet_03v3 L=2.5U W=6.33U AS=1.6458P AD=1.6458P
+ PS=6.85U PD=6.85U
M$4 \$I18 \$12 \$I15 SUB nfet_03v3 L=2.5U W=6.33U AS=1.6458P AD=1.6458P
+ PS=6.85U PD=6.85U
M$5 \$I19 \$12 \$I18 SUB nfet_03v3 L=2.5U W=6.33U AS=1.6458P AD=1.6458P
+ PS=6.85U PD=6.85U
M$6 \$I21 \$12 \$I19 SUB nfet_03v3 L=2.5U W=6.33U AS=1.6458P AD=1.6458P
+ PS=6.85U PD=6.85U
M$7 \$I20 \$12 \$I21 SUB nfet_03v3 L=2.5U W=6.33U AS=1.6458P AD=1.6458P
+ PS=6.85U PD=6.85U
M$8 \$I22 \$12 \$I20 SUB nfet_03v3 L=2.5U W=6.33U AS=1.6458P AD=1.6458P
+ PS=6.85U PD=6.85U
M$9 \$I23 \$12 \$I22 SUB nfet_03v3 L=2.5U W=6.33U AS=1.6458P AD=1.6458P
+ PS=6.85U PD=6.85U
M$10 \$7 \$12 \$I23 SUB nfet_03v3 L=2.5U W=6.33U AS=1.6458P AD=3.8613P PS=6.85U
+ PD=13.88U
M$11 \$I32 \$18 \$14 \$17 pfet_03v3 L=2.5U W=0.42U AS=0.2822P AD=0.1092P
+ PS=2.18U PD=0.94U
M$12 \$I31 \$18 \$I32 \$17 pfet_03v3 L=2.5U W=0.42U AS=0.1092P AD=0.1092P
+ PS=0.94U PD=0.94U
M$13 \$I30 \$18 \$I31 \$17 pfet_03v3 L=2.5U W=0.42U AS=0.1092P AD=0.1092P
+ PS=0.94U PD=0.94U
M$14 \$I29 \$18 \$I30 \$17 pfet_03v3 L=2.5U W=0.42U AS=0.1092P AD=0.1092P
+ PS=0.94U PD=0.94U
M$15 \$I27 \$18 \$I29 \$17 pfet_03v3 L=2.5U W=0.42U AS=0.1092P AD=0.1092P
+ PS=0.94U PD=0.94U
M$16 \$I26 \$18 \$I27 \$17 pfet_03v3 L=2.5U W=0.42U AS=0.1092P AD=0.1092P
+ PS=0.94U PD=0.94U
M$17 \$I28 \$18 \$I26 \$17 pfet_03v3 L=2.5U W=0.42U AS=0.1092P AD=0.1092P
+ PS=0.94U PD=0.94U
M$18 \$I28 \$18 \$17 \$17 pfet_03v3 L=2.5U W=0.42U AS=0.2822P AD=0.1092P
+ PS=2.18U PD=0.94U
M$19 \$I35 \$20 \$4 \$17 pfet_03v3 L=2.5U W=0.42U AS=0.2822P AD=0.1092P
+ PS=2.18U PD=0.94U
M$20 \$I34 \$20 \$I35 \$17 pfet_03v3 L=2.5U W=0.42U AS=0.1092P AD=0.1092P
+ PS=0.94U PD=0.94U
M$21 \$I33 \$20 \$I34 \$17 pfet_03v3 L=2.5U W=0.42U AS=0.1092P AD=0.1092P
+ PS=0.94U PD=0.94U
M$22 \$I33 \$20 \$17 \$17 pfet_03v3 L=2.5U W=0.42U AS=0.2822P AD=0.1092P
+ PS=2.18U PD=0.94U
M$23 \$I38 \$18 \$18 \$17 pfet_03v3 L=2.5U W=0.42U AS=0.2822P AD=0.1092P
+ PS=2.18U PD=0.94U
M$24 \$I37 \$18 \$I38 \$17 pfet_03v3 L=2.5U W=0.42U AS=0.1092P AD=0.1092P
+ PS=0.94U PD=0.94U
M$25 \$I36 \$18 \$I37 \$17 pfet_03v3 L=2.5U W=0.42U AS=0.1092P AD=0.1092P
+ PS=0.94U PD=0.94U
M$26 \$I36 \$18 \$17 \$17 pfet_03v3 L=2.5U W=0.42U AS=0.2822P AD=0.1092P
+ PS=2.18U PD=0.94U
M$27 \$I45 \$4 \$7 SUB nfet_03v3 L=2.5U W=0.42U AS=0.2646P AD=0.1092P PS=2.1U
+ PD=0.94U
M$28 \$I44 \$4 \$I45 SUB nfet_03v3 L=2.5U W=0.42U AS=0.1092P AD=0.1092P
+ PS=0.94U PD=0.94U
M$29 \$I43 \$4 \$I44 SUB nfet_03v3 L=2.5U W=0.42U AS=0.1092P AD=0.1092P
+ PS=0.94U PD=0.94U
M$30 \$I42 \$4 \$I43 SUB nfet_03v3 L=2.5U W=0.42U AS=0.1092P AD=0.1092P
+ PS=0.94U PD=0.94U
M$31 \$I40 \$4 \$I42 SUB nfet_03v3 L=2.5U W=0.42U AS=0.1092P AD=0.1092P
+ PS=0.94U PD=0.94U
M$32 \$I39 \$4 \$I40 SUB nfet_03v3 L=2.5U W=0.42U AS=0.1092P AD=0.1092P
+ PS=0.94U PD=0.94U
M$33 \$I41 \$4 \$I39 SUB nfet_03v3 L=2.5U W=0.42U AS=0.1092P AD=0.1092P
+ PS=0.94U PD=0.94U
M$34 \$I41 \$4 SUB SUB nfet_03v3 L=2.5U W=0.42U AS=0.2646P AD=0.1092P PS=2.1U
+ PD=0.94U
M$35 \$I48 \$4 \$18 SUB nfet_03v3 L=2.5U W=0.42U AS=0.2646P AD=0.1092P PS=2.1U
+ PD=0.94U
M$36 \$I47 \$4 \$I48 SUB nfet_03v3 L=2.5U W=0.42U AS=0.1092P AD=0.1092P
+ PS=0.94U PD=0.94U
M$37 \$I46 \$4 \$I47 SUB nfet_03v3 L=2.5U W=0.42U AS=0.1092P AD=0.1092P
+ PS=0.94U PD=0.94U
M$38 \$I46 \$4 SUB SUB nfet_03v3 L=2.5U W=0.42U AS=0.2646P AD=0.1092P PS=2.1U
+ PD=0.94U
M$39 \$I51 \$4 \$4 SUB nfet_03v3 L=2.5U W=0.42U AS=0.2646P AD=0.1092P PS=2.1U
+ PD=0.94U
M$40 \$I50 \$4 \$I51 SUB nfet_03v3 L=2.5U W=0.42U AS=0.1092P AD=0.1092P
+ PS=0.94U PD=0.94U
M$41 \$I49 \$4 \$I50 SUB nfet_03v3 L=2.5U W=0.42U AS=0.1092P AD=0.1092P
+ PS=0.94U PD=0.94U
M$42 \$I49 \$4 SUB SUB nfet_03v3 L=2.5U W=0.42U AS=0.2646P AD=0.1092P PS=2.1U
+ PD=0.94U
M$43 \$I53 \$11 \$3 \$13 pfet_03v3 L=2.5U W=15.825U AS=10.28625P AD=4.1145P
+ PS=32.95U PD=16.345U
M$44 \$I52 \$11 \$I53 \$13 pfet_03v3 L=2.5U W=15.825U AS=4.1145P AD=4.1145P
+ PS=16.345U PD=16.345U
M$45 \$I55 \$11 \$I52 \$13 pfet_03v3 L=2.5U W=15.825U AS=4.1145P AD=4.1145P
+ PS=16.345U PD=16.345U
M$46 \$I54 \$11 \$I55 \$13 pfet_03v3 L=2.5U W=15.825U AS=4.1145P AD=4.1145P
+ PS=16.345U PD=16.345U
M$47 \$I57 \$11 \$I54 \$13 pfet_03v3 L=2.5U W=15.825U AS=4.1145P AD=4.1145P
+ PS=16.345U PD=16.345U
M$48 \$I56 \$11 \$I57 \$13 pfet_03v3 L=2.5U W=15.825U AS=4.1145P AD=4.1145P
+ PS=16.345U PD=16.345U
M$49 \$I59 \$11 \$I56 \$13 pfet_03v3 L=2.5U W=15.825U AS=4.1145P AD=4.1145P
+ PS=16.345U PD=16.345U
M$50 \$I58 \$11 \$I59 \$13 pfet_03v3 L=2.5U W=15.825U AS=4.1145P AD=4.1145P
+ PS=16.345U PD=16.345U
M$51 \$I60 \$11 \$I58 \$13 pfet_03v3 L=2.5U W=15.825U AS=4.1145P AD=4.1145P
+ PS=16.345U PD=16.345U
M$52 \$14 \$11 \$I60 \$13 pfet_03v3 L=2.5U W=15.825U AS=4.1145P AD=10.28625P
+ PS=16.345U PD=32.95U
.ENDS OSC_INV
