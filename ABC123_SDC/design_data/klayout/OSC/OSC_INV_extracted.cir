* Extracted by KLayout with GF180MCU LVS runset on : 17/08/2026 04:01

.SUBCKT OSC_INV mirror mirror2 Nnet VOUT VIN VDD Pnet Vcont VSS
M$1 VOUT VIN VOUT VDD pfet_03v3 L=2.5U W=142.425U AS=43.20225P AD=37.0305P
+ PS=163.71U PD=147.105U
M$10 Pnet VIN VOUT VDD pfet_03v3 L=2.5U W=15.825U AS=4.1145P AD=10.28625P
+ PS=16.345U PD=32.95U
M$11 mirror mirror mirror VSS nfet_03v3 L=2.5U W=1.26U AS=0.483P AD=0.3276P
+ PS=3.98U PD=2.82U
M$14 mirror mirror VSS VSS nfet_03v3 L=2.5U W=0.42U AS=0.2646P AD=0.1092P
+ PS=2.1U PD=0.94U
M$15 VOUT VIN VOUT VSS nfet_03v3 L=2.5U W=56.97U AS=17.0277P AD=14.8122P
+ PS=68.68U PD=61.65U
M$24 Nnet VIN VOUT VSS nfet_03v3 L=2.5U W=6.33U AS=1.6458P AD=3.8613P PS=6.85U
+ PD=13.88U
M$25 Nnet mirror VSS VSS nfet_03v3 L=2.5U W=0.42U AS=0.2646P AD=0.1092P PS=2.1U
+ PD=0.94U
M$26 Nnet mirror Nnet VSS nfet_03v3 L=2.5U W=2.94U AS=0.9198P AD=0.7644P
+ PS=7.74U PD=6.58U
M$33 Pnet mirror2 Pnet VDD pfet_03v3 L=2.5U W=2.94U AS=0.9374P AD=0.7644P
+ PS=7.82U PD=6.58U
M$40 Pnet mirror2 VDD VDD pfet_03v3 L=2.5U W=0.42U AS=0.2822P AD=0.1092P
+ PS=2.18U PD=0.94U
M$41 mirror Vcont mirror VDD pfet_03v3 L=2.5U W=1.26U AS=0.5006P AD=0.3276P
+ PS=4.06U PD=2.82U
M$44 mirror Vcont VDD VDD pfet_03v3 L=2.5U W=0.42U AS=0.2822P AD=0.1092P
+ PS=2.18U PD=0.94U
M$45 mirror2 mirror2 mirror2 VDD pfet_03v3 L=2.5U W=1.26U AS=0.5006P AD=0.3276P
+ PS=4.06U PD=2.82U
M$48 mirror2 mirror2 VDD VDD pfet_03v3 L=2.5U W=0.42U AS=0.2822P AD=0.1092P
+ PS=2.18U PD=0.94U
M$49 mirror2 mirror mirror2 VSS nfet_03v3 L=2.5U W=1.26U AS=0.483P AD=0.3276P
+ PS=3.98U PD=2.82U
M$52 mirror2 mirror VSS VSS nfet_03v3 L=2.5U W=0.42U AS=0.2646P AD=0.1092P
+ PS=2.1U PD=0.94U
.ENDS OSC_INV
