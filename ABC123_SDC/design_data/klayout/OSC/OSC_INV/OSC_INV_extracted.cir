* Extracted by KLayout with GF180MCU LVS runset on : 26/08/2026 05:47

.SUBCKT OSC_INV VOUT VDD VIN Vcont VSS
M$1 VOUT VIN \$8 VDD pfet_03v3 L=2.5U W=158.25U AS=47.31675P AD=47.31675P
+ PS=180.055U PD=180.055U
M$11 \$2 \$2 VSS VSS nfet_03v3 L=2.5U W=1.68U AS=0.7476P AD=0.4368P PS=6.08U
+ PD=3.76U
M$15 VOUT VIN \$3 VSS nfet_03v3 L=2.5U W=63.3U AS=18.6735P AD=18.6735P
+ PS=75.53U PD=75.53U
M$25 \$3 \$2 VSS VSS nfet_03v3 L=2.5U W=3.36U AS=1.1844P AD=0.8736P PS=9.84U
+ PD=7.52U
M$33 \$8 \$11 VDD VDD pfet_03v3 L=2.5U W=3.36U AS=1.2196P AD=0.8736P PS=10U
+ PD=7.52U
M$41 \$2 Vcont VDD VDD pfet_03v3 L=2.5U W=1.68U AS=0.7828P AD=0.4368P PS=6.24U
+ PD=3.76U
M$45 \$11 \$11 VDD VDD pfet_03v3 L=2.5U W=1.68U AS=0.7828P AD=0.4368P PS=6.24U
+ PD=3.76U
M$49 \$11 \$2 VSS VSS nfet_03v3 L=2.5U W=1.68U AS=0.7476P AD=0.4368P PS=6.08U
+ PD=3.76U
.ENDS OSC_INV
