** sch_path: /foss/designs/SSCS-Chipathon-2026_ABC123-team/ABC123_SDC/design_data/klayout/OSC/OSC_RING/OSC_RING.sch
.subckt OSC_RING VDD N2 N1 SENS_IN VSS Vcont
*.PININFO SENS_IN:I VDD:B VSS:B N1:O N2:O Vcont:I
x2 VDD SENS_IN N1 VSS Vcont OSC_INV
x3 VDD N1 Pre_buff VSS Vcont OSC_INV
x4 VDD Pre_buff SENS_IN VSS Vcont OSC_INV
x1 Pre_buff N2 VDD VSS BUFF
.ends

* expanding   symbol:  /foss/designs/SSCS-Chipathon-2026_ABC123-team/ABC123_SDC/design_data/klayout/OSC/OSC_INV/OSC_INV.sym # of
*+ pins=5
** sym_path: /foss/designs/SSCS-Chipathon-2026_ABC123-team/ABC123_SDC/design_data/klayout/OSC/OSC_INV/OSC_INV.sym
** sch_path: /foss/designs/SSCS-Chipathon-2026_ABC123-team/ABC123_SDC/design_data/klayout/OSC/OSC_INV/OSC_INV.sch
.subckt OSC_INV VDD VIN VOUT VSS Vcont
*.PININFO VIN:I VOUT:O VDD:B VSS:B Vcont:I
M4 net2 net3 VSS VSS nfet_03v3 L=2.5u W=0.42u nf=1 m=8
M5 net1 net4 VDD VDD pfet_03v3 L=2.5u W=0.42u nf=1 m=8
M6 net4 net3 VSS VSS nfet_03v3 L=2.5u W=0.42u nf=1 m=4
M7 net4 net4 VDD VDD pfet_03v3 L=2.5u W=0.42u nf=1 m=4
M8 net3 net3 VSS VSS nfet_03v3 L=2.5u W=0.42u nf=1 m=4
M9 net3 Vcont VDD VDD pfet_03v3 L=2.5u W=0.42u nf=1 m=4
M1 VOUT VIN net1 VDD pfet_03v3 L=2.5u W=15.825u nf=1 m=10
M2 VOUT VIN net2 VSS nfet_03v3 L=2.5u W=6.33u nf=1 m=10
.ends

* expanding   symbol:  /foss/designs/SSCS-Chipathon-2026_ABC123-team/ABC123_SDC/design_data/klayout/BUFF/BUFF.sym # of pins=4
** sym_path: /foss/designs/SSCS-Chipathon-2026_ABC123-team/ABC123_SDC/design_data/klayout/BUFF/BUFF.sym
** sch_path: /foss/designs/SSCS-Chipathon-2026_ABC123-team/ABC123_SDC/design_data/klayout/BUFF/BUFF.sch
.subckt BUFF VIN VOUT VDD VSS
*.PININFO VIN:I VDD:B VSS:B VOUT:O
M1 MID_BUFF VIN VDD VDD pfet_03v3 L=0.28u W=1.87u nf=1
M2 MID_BUFF VIN VSS VSS nfet_03v3 L=0.28u W=1.87u nf=1
M3 VOUT MID_BUFF VDD VDD pfet_03v3 L=0.28u W=1.87u nf=1
M4 VOUT MID_BUFF VSS VSS nfet_03v3 L=0.28u W=1.87u nf=1
.ends
