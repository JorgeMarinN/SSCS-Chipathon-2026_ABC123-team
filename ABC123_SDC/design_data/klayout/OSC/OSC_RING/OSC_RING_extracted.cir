* Extracted by KLayout with GF180MCU LVS runset on : 26/08/2026 06:06

.SUBCKT OSC_RING N2 N1|VIN VDD Vcont SUB \$4.VIN
X$1 N1|VIN N2 VDD SUB BUFF
X$3 N1|VIN \$6 N1|VIN Vcont SUB OSC_INV
M$1 N1|VIN \$4.VIN \$I5 \$6 pfet_03v3 L=2.5U W=158.25U AS=47.31675P
+ AD=47.31675P PS=180.055U PD=180.055U
M$11 \$I1 \$I1 SUB SUB nfet_03v3 L=2.5U W=1.68U AS=0.7476P AD=0.4368P PS=6.08U
+ PD=3.76U
M$15 N1|VIN \$4.VIN \$I2 SUB nfet_03v3 L=2.5U W=63.3U AS=18.6735P AD=18.6735P
+ PS=75.53U PD=75.53U
M$25 \$I2 \$I1 SUB SUB nfet_03v3 L=2.5U W=3.36U AS=1.1844P AD=0.8736P PS=9.84U
+ PD=7.52U
M$33 \$I5 \$I6 \$6 \$6 pfet_03v3 L=2.5U W=3.36U AS=1.2196P AD=0.8736P PS=10U
+ PD=7.52U
M$41 \$I1 Vcont \$6 \$6 pfet_03v3 L=2.5U W=1.68U AS=0.7828P AD=0.4368P PS=6.24U
+ PD=3.76U
M$45 \$I6 \$I6 \$6 \$6 pfet_03v3 L=2.5U W=1.68U AS=0.7828P AD=0.4368P PS=6.24U
+ PD=3.76U
M$49 \$I6 \$I1 SUB SUB nfet_03v3 L=2.5U W=1.68U AS=0.7476P AD=0.4368P PS=6.08U
+ PD=3.76U
M$53 N1|VIN N1|VIN \$I10 \$6 pfet_03v3 L=2.5U W=158.25U AS=47.31675P
+ AD=47.31675P PS=180.055U PD=180.055U
M$63 \$I7 \$I7 SUB SUB nfet_03v3 L=2.5U W=1.68U AS=0.7476P AD=0.4368P PS=6.08U
+ PD=3.76U
M$67 N1|VIN N1|VIN \$I8 SUB nfet_03v3 L=2.5U W=63.3U AS=18.6735P AD=18.6735P
+ PS=75.53U PD=75.53U
M$77 \$I8 \$I7 SUB SUB nfet_03v3 L=2.5U W=3.36U AS=1.1844P AD=0.8736P PS=9.84U
+ PD=7.52U
M$85 \$I10 \$I11 \$6 \$6 pfet_03v3 L=2.5U W=3.36U AS=1.2196P AD=0.8736P PS=10U
+ PD=7.52U
M$93 \$I7 Vcont \$6 \$6 pfet_03v3 L=2.5U W=1.68U AS=0.7828P AD=0.4368P PS=6.24U
+ PD=3.76U
M$97 \$I11 \$I11 \$6 \$6 pfet_03v3 L=2.5U W=1.68U AS=0.7828P AD=0.4368P
+ PS=6.24U PD=3.76U
M$101 \$I11 \$I7 SUB SUB nfet_03v3 L=2.5U W=1.68U AS=0.7476P AD=0.4368P
+ PS=6.08U PD=3.76U
.ENDS OSC_RING

.SUBCKT BUFF VIN VOUT VDD VSS
M$1 VDD VIN \$2 VDD pfet_03v3 L=0.28U W=1.87U AS=2.057P AD=0.4862P PS=5.94U
+ PD=2.39U
M$2 VOUT \$2 VDD VDD pfet_03v3 L=0.28U W=1.87U AS=0.4862P AD=2.057P PS=2.39U
+ PD=5.94U
M$3 VSS VIN \$2 VSS nfet_03v3 L=0.28U W=1.87U AS=2.057P AD=0.4862P PS=5.94U
+ PD=2.39U
M$4 VOUT \$2 VSS VSS nfet_03v3 L=0.28U W=1.87U AS=0.4862P AD=2.057P PS=2.39U
+ PD=5.94U
.ENDS BUFF

.SUBCKT OSC_INV VOUT VDD VIN Vcont VSS
M$1 VOUT VIN \$8 VDD pfet_03v3 L=2.5U W=158.25U AS=47.31675P AD=47.31675P
+ PS=180.055U PD=180.055U
M$11 \$2 \$2 VSS VSS nfet_03v3 L=2.5U W=1.68U AS=0.7476P AD=0.4368P PS=6.08U
+ PD=3.76U
M$15 VOUT VIN \$3 VSS nfet_03v3 L=2.5U W=63.3U AS=18.6735P AD=18.6735P
+ PS=75.53U PD=75.53U
M$25 \$3 \$2 VSS VSS nfet_03v3 L=2.5U W=3.36U AS=1.1844P AD=0.8736P PS=9.84U
+ PD=7.52U
M$33 \$8 \$11 VDD VDD pfet_03v3 L=2.5U W=3.36U AS=1.2196P AD=0.8736P PS=10U
+ PD=7.52U
M$41 \$2 Vcont VDD VDD pfet_03v3 L=2.5U W=1.68U AS=0.7828P AD=0.4368P PS=6.24U
+ PD=3.76U
M$45 \$11 \$11 VDD VDD pfet_03v3 L=2.5U W=1.68U AS=0.7828P AD=0.4368P PS=6.24U
+ PD=3.76U
M$49 \$11 \$2 VSS VSS nfet_03v3 L=2.5U W=1.68U AS=0.7476P AD=0.4368P PS=6.08U
+ PD=3.76U
.ENDS OSC_INV
